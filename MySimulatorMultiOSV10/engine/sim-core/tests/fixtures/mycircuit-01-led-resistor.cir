LED and resistor - generated by MyCircuit
VBT1 VBAT 0 DC 9
RSW1 VBAT SW_OUT 0.01 ; switch closed
R1 SW_OUT LED_A 470
D1 LED_A 0 D_D1

.model D_D1 D(IS=1e-19 N=1.8 RS=10)

.op
.end
