Non-inverting amplifier (gain 11) - generated by MyCircuit
V1 _12V 0 DC 12
V2 0 _12V_ DC 12
V3 IN 0 DC 0 SIN(0 0.5 1000 0 0 0)
XU1 IN FB OUT _12V _12V_ OPAMP_U1
R2 FB OUT 100000
R3 FB 0 10000
R1 OUT 0 10000

.subckt OPAMP_U1 inp inn out vp vn
B1 out 0 V=max(min(100000*(V(inp)-V(inn)), V(vp)), V(vn))
.ends

.tran 2u 3m
.end
