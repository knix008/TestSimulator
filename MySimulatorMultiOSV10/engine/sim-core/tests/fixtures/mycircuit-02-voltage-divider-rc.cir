Voltage divider + RC low-pass - generated by MyCircuit
V1 IN 0 DC 0 SIN(0 2 1000 0 0 0)
R1 IN DIV 10000
R3 DIV 0 10000
R2 DIV OUT 1000
C1 OUT 0 1e-7

.ac dec 20 10 100k
.end
