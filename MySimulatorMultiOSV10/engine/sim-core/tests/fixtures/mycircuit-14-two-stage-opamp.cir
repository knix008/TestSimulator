Two-stage amplifier (gain -4) - generated by MyCircuit
V1 _12V 0 DC 12
V2 0 _12V_ DC 12
V3 IN 0 DC 0 SIN(0 0.5 1000 0 0 0)
XU1 IN Net-_R4-Pad1_ MID _12V _12V_ OPAMP_U1
R5 Net-_R4-Pad1_ 0 10000
R4 Net-_R4-Pad1_ MID 10000
R2 MID OUT 10000
XU2 0 OUT OUT _12V _12V_ OPAMP_U2
R1 OUT OUT 20000
R3 OUT 0 10000

.subckt OPAMP_U1 inp inn out vp vn
B1 out 0 V=max(min(100000*(V(inp)-V(inn)), V(vp)), V(vn))
.ends
.subckt OPAMP_U2 inp inn out vp vn
B1 out 0 V=max(min(100000*(V(inp)-V(inn)), V(vp)), V(vn))
.ends

.tran 2u 3m
.end
