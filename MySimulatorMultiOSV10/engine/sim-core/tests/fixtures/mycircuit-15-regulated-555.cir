Regulated 555 blinker - generated by MyCircuit
V1 VRAW 0 DC 12
RF1 VRAW Net-_D1-Pad2_ 0.05
D1 Net-_D1-Pad2_ VIN D_D1
C2 VIN 0 0.0001
XU1 VIN _5V 0 REG_U1
C3 _5V 0 0.00001
C4 _5V 0 1e-7
R4 _5V Net-_D3-Pad2_ 1000
D3 Net-_D3-Pad2_ 0 D_D3
C1 _5V 0 1e-7
R1 _5V DIS 1000
R2 DIS Net-_C5-Pad1_ 47000
C5 Net-_C5-Pad1_ 0 0.00001
C6 Net-_C6-Pad1_ 0 1e-8
R3 Net-_R3-Pad1_ Net-_D2-Pad2_ 470
D2 Net-_D2-Pad2_ 0 D_D2

.model D_D1 D(IS=2.52e-9 N=1.752)
.model D_D3 D(IS=1e-19 N=1.8 RS=10)
.model D_D2 D(IS=1e-19 N=1.8 RS=10)

.subckt REG_U1 in out gnd
B1 x gnd V=max(min(5, V(in,gnd)-2), 0)
VSNS x xo 0
R1 xo out 0.1
F1 in gnd VSNS 1
IQ in gnd DC 0.005
.ends

.op
* U2: NE555 timer has no simulation model, ignored
.end
