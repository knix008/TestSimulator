5 V power supply (LM7805) - generated by MyCircuit
V1 VRAW 0 DC 12
RF1 VRAW Net-_D1-Pad2_ 0.05
D1 Net-_D1-Pad2_ VIN D_D1
C1 VIN 0 0.0001
XU1 VIN _5V 0 REG_U1
C2 _5V 0 0.00001
C3 _5V 0 1e-7
R1 _5V Net-_D2-Pad2_ 1000
D2 Net-_D2-Pad2_ 0 D_D2

.model D_D1 D(IS=2.52e-9 N=1.752)
.model D_D2 D(IS=1e-19 N=1.8 RS=10)

.subckt REG_U1 in out gnd
B1 x gnd V=max(min(5, V(in,gnd)-2), 0)
VSNS x xo 0
R1 xo out 0.1
F1 in gnd VSNS 1
IQ in gnd DC 0.005
.ends

.op
* J1: Connector 1×2 has no simulation model, ignored
.end
