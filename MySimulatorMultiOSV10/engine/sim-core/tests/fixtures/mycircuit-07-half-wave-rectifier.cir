Half-wave rectifier - generated by MyCircuit
V1 AC_IN 0 DC 0 SIN(0 12 50 0 0 0)
D1 AC_IN VOUT D_D1
C1 VOUT 0 0.00047
R1 VOUT 0 1000

.model D_D1 D(IS=2.52e-9 N=1.752)

.tran 100u 100m
.end
