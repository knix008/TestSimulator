NPN transistor switch - generated by MyCircuit
VBT1 VCC 0 DC 4.5
RSW1 VCC SW_OUT 0.01 ; switch closed
R2 SW_OUT BASE 10000
R3 BASE 0 100000
Q1 LED_K BASE 0 Q_Q1
R1 VCC Net-_D1-Pad2_ 220
D1 Net-_D1-Pad2_ LED_K D_D1

.model Q_Q1 NPN(IS=6.7e-15 BF=200 BR=2)
.model D_D1 D(IS=1e-19 N=1.8 RS=10)

.op
.end
